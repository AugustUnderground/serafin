subckt op B INP INN O VDD VSS
    MNCM11 (B  B   VSS VSS) nmos1 m=Mcm11 w=Wcm1 l=Lcm1
    MNCM12 (CM B   VSS VSS) nmos1 m=Mcm12 w=Wcm1 l=Lcm1

    MNDP11 (Y  INN CM  VSS) nmos1 m=Mdp11 w=Wdp1 l=Ldp1
    MNDP12 (X  INP CM  VSS) nmos1 m=Mdp12 w=Wdp1 l=Ldp1

    MPCM21 (Y  Y   VDD VDD) pmos1 m=Mcm21 w=Wcm2 l=Lcm2
    MPCM22 (Z  Y   VDD VDD) pmos1 m=Mcm22 w=Wcm2 l=Lcm2

    MPCM31 (X  X   VDD VDD) pmos1 m=Mcm31 w=Wcm3 l=Lcm3
    MPCM32 (O  X   VDD VDD) pmos1 m=Mcm32 w=Wcm3 l=Lcm3

    MNCM41 (Z  Z   VSS VSS) nmos1 m=Mcm41 w=Wcm4 l=Lcm4
    MNCM42 (O  Z   VSS VSS) nmos1 m=Mcm42 w=Wcm4 l=Lcm4
ends op
