subckt op B INP INN O VDD VSS
    // NMOS Current Mirror 1
    MNCM11 (B  B   VSS VSS) nmos w=Wcm1 l=Lcm1 m=Mcm11
    MNCM12 (CM B   VSS VSS) nmos w=Wcm1 l=Lcm1 m=Mcm12

    // NMOS Differential Pair 1
    MNDP11 (Y  INN CM  VSS) nmos w=Wdp1 l=Ldp1 m=Mdp11
    MNDP12 (X  INP CM  VSS) nmos w=Wdp1 l=Ldp1 m=Mdp12

    // PMOS Current Mirror 2
    MPCM21 (Y  Y   VDD VDD) pmos w=Wcm2 l=Lcm2 m=Mcm21
    MPCM22 (Z  Y   VDD VDD) pmos w=Wcm2 l=Lcm2 m=Mcm22

    // PMOS Current Mirror 3
    MPCM31 (X  X   VDD VDD) pmos w=Wcm3 l=Lcm3 m=Mcm31
    MPCM32 (O  X   VDD VDD) pmos w=Wcm3 l=Lcm3 m=Mcm32

    // NMOS Current Mirror 4
    MNCM41 (Z  Z   VSS VSS) nmos w=Wcm4 l=Ldp1 m=Mcm41
    MNCM42 (O  Z   VSS VSS) nmos w=Wcm4 l=Ldp1 m=Mcm42
ends op
